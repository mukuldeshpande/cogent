`include "discipline.h"
`include "constants.h"

// $Date: 1997/08/28 05:53:24 $
// $Revision: 1.1 $

//
// Based on the OVI Verilog-A Language Reference Manual, version 1.0 1996
//
//
//

`define arg   0
`define rise  1
`define fall  2
`define cross 3
`define at    10
`define when  11

//--------------------
// delta_probe
//
// -  Delta probe
//
// start_pos, start_neg:	signal that controls start of measurement []
// stop_pos, stop_neg: 		signal that controls end of measurement []
//
// INSTANCE parameters
//    start_td, stop_td       = signal delays [s]
//    start_val, stop_val     = signal value that starts/end measurement []
//    start_count, stop_count = num signal values that starts/end measurement
//    start_mode              = one of starting/stopping modes []
//                              0 => arg - argument value (simulation time)
//		                1 => rise - crossing of signal value on rise
//		                2 => fall - crossing of signal value on fall
//		                3 => cross - any crossing of the signal value
//    stop_mode               = one of starting/stopping modes []
//                              0 => arg - argument value (simulation time)
//		                1 => rise - crossing of signal value on rise
//		                2 => fall - crossing of signal value on fall
//		                3 => cross - any crossing of the signal value
//
// MODEL parameters
//    {none}
//
// This probe measures argument delta between occurence of the starting
// and stoping events. It can be also used to find when start and
// stop signals cross the specified reference values;
// (by default start_count and stop_count are set to 1).
//

(* instrument_module *)
module delta_probe (start_pos, start_neg, stop_pos, stop_neg);
inout start_pos, start_neg, stop_pos, stop_neg;
electrical start_pos, start_neg, stop_pos, stop_neg;
parameter real start_val = 0;
parameter real start_td = 0;
parameter integer start_count = 1;
parameter real stop_val = 0;
parameter real stop_td = 0;
parameter integer stop_count = 1;
parameter integer  start_mode = 1;
parameter integer stop_mode = 1;

   integer startDirection, stopDirection;
   real argstartCur, argstopCur;
   real sDelay;

   real startCross, stopCross;
   integer startCnt, stopCnt;
   real argstartPrev, argstopPrev;

   real lc_startDirection, lc_stopDirection;
   integer crossStartDirection;
   integer crossStopDirection;

   analog function integer direction;
   input mode;
   integer mode;

      if (mode == `rise) direction = 1;
      else if (mode == `fall) direction = -1;
      else if (mode == `cross) direction = 0;
   endfunction

   analog begin

      @ ( initial_step ) begin
	  startCross = -1M;
	  startDirection = direction(start_mode);
	  stopDirection = direction(stop_mode);
      end

      if (analysis("tran")) begin
         lc_startDirection = last_crossing(V(start_pos, start_neg) -
                                           start_val, startDirection);
         lc_stopDirection = last_crossing(V(stop_pos, stop_neg) -
         stop_val, stopDirection);

	 crossStartDirection = 0;
	 crossStopDirection = 0;

	 argstartCur = 0.0;
	 argstopCur = 0.0;

         @ (cross(V(start_pos, start_neg) - start_val, startDirection)) begin
		crossStartDirection = 1;
	 end

         @ (cross(V(stop_pos, stop_neg) - stop_val, stopDirection)) begin
		crossStopDirection = 1;
	 end

         if (startCross == -1M) begin
	    argstartCur = lc_startDirection;
            if ($abstime - start_td >= 0) begin
               if (startCnt+1 == start_count) begin
		  if ( crossStartDirection ) begin
                      startCross = argstartCur;
                  end
               end

               if ( argstartCur != argstartPrev)
                  startCnt = startCnt + 1;
            end
         end

         if (stopCross == 0) begin
	    argstopCur = lc_stopDirection;
            if ($abstime - stop_td >= 0) begin
               if (stopCnt+1 == stop_count) begin
		  if ( crossStopDirection ) begin
                      stopCross = argstopCur;
                  end
               end

            if ( argstopCur != argstopPrev)
                               stopCnt = stopCnt + 1;
            end
         end
         argstartPrev = argstartCur;
         argstopPrev = argstopCur;
      end

      @ ( final_step ) begin
	 if (analysis("tran")) begin
	    $strobe("\nModule instance: %M\n");
	    if (startCross == 0)
	       $strobe("\n starting event did not occur.");
	    if (stopCross == 0)
	       $strobe("    stoping event did not occur.");
	    if (startCross > 0 && stopCross > 0) begin
	       sDelay = stopCross - startCross;
	       $strobe("    Start argument = %2.12g s.\n", startCross);
	       $strobe("    Stop argument = %2.12g s.\n", stopCross);
	       $strobe("    Delta = %2.12g s.\n", sDelay);
               $strobe("    %M_value=%2.12g s.\n", sDelay);
	    end
	 end
      end

   end
endmodule
