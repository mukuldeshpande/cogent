// //T6AS SPICE BSIM3 VERSION 3.1 PARAMETERS
simulator lang=spectre insensitive=yes
//  SPICE 3f5 Level 8, Star-HSPICE Level 49, UTMOST Level 8

//  DATE: Jan 29/07
//  LOT: T6AS                  WAF: 2001
//  Temperature_parameters=Default
model cmosn bsim3v3 type=n
+ version=3.1               tnom=27                   tox=3.1e-9
+ xj=1e-7                   nch=2.3549e17             vth0=0.0791064
+ k1=0.2786035              k2=-2.393594e-3           k3=1e-3
+ k3b=9.6437981             w0=1e-7                   nlx=1e-6
+ dvt0w=0                   dvt1w=0                   dvt2w=0
+ dvt0=0.9714952            dvt1=0.1775388            dvt2=0.3120414
+ u0=404.010942             ua=-1.44158e-9            ub=4.968899e-18
+ uc=4.729303e-10           vsat=1.856067e5           a0=0.8111373
+ ags=1.0863054             b0=7.635288e-6            b1=5e-6
+ keta=0.05                 a1=6.975594e-5            a2=0.3
+ rdsw=150                  prwg=0.4978219            prwb=0.2
+ wr=1                      wint=1.373377e-8          lint=1.191342e-8
+ dwg=4.455874e-9           dwb=4.029588e-8           voff=-0.0662459
+ nfactor=2.5               cit=0                     cdsc=2.4e-4
+ cdscd=0                   cdscb=0                   eta0=1.152248e-3
+ etab=-0.0192992           dsub=8.193977e-4          pclm=1.3587524
+ pdiblc1=0.4534273         pdiblc2=0.01              pdiblcb=0.1
+ drout=0.9991682           pscbe1=7.990606e10        pscbe2=5.674888e-8
+ pvag=1.300698e-3          delta=0.01                rsh=7.1
+ mobmod=1                  prt=0                     ute=-1.5
+ kt1=-0.11                 kt1l=0                    kt2=0.022
+ ua1=4.31e-9               ub1=-7.61e-18             uc1=-5.6e-11
+ at=3.3e4                  wl=0                      wln=1
+ ww=0                      wwn=1                     wwl=0
+ ll=0                      lln=1                     lw=0
+ lwn=1                     lwl=0                     capmod=2
+ xpart=0.5                 cgdo=3.93e-10             cgso=3.93e-10
+ cgbo=1e-12                cj=8.395926e-4            pb=0.8452447
+ mj=0.5347241              cjsw=2.43093e-10          pbsw=0.8
+ mjsw=0.2862575            cjswg=3.3e-10             pbswg=0.8
+ mjswg=0.2862575           cf=0                      pvth0=-5.064056e-4
+ prdsw=0                   pk2=1.334579e-3           wketa=4.566422e-3
+ lketa=3.013288e-3         pu0=-1.7695815            pua=-2.40836e-11
+ pub=0                     pvsat=2e3                 peta0=1.1e-4
+ pketa=4.448585e-3         wlod=1.998729e-6          kvsat=0.1989501
+ llodku0=1.1               wlodku0=0.0122576         llodvth=0.9990053
+ wlodvth=1.002888e-3       lku0=9e-6                 wku0=1e-6
+ lkvth0=8.991048e-5        wkvth0=8.994281e-5        pkvth0=-1e-7
//

model cmosp bsim3v3 type=p
+ version=3.1               tnom=27                   tox=3.1e-9
+ xj=1e-7                   nch=4.1589e17             vth0=-0.2210436
+ k1=0.1991668              k2=0.034267               k3=0.0997959
+ k3b=10.5839153            w0=1e-6                   nlx=3.9532e-7
+ dvt0w=0                   dvt1w=0                   dvt2w=0
+ dvt0=0                    dvt1=2.729115e-3          dvt2=0.0489008
+ u0=116.4033083            ua=1.386404e-9            ub=1.074726e-21
+ uc=3.221322e-11           vsat=1.653068e5           a0=2
+ ags=0.4466853             b0=3.565587e-7            b1=5e-6
+ keta=0.05                 a1=9.445251e-4            a2=0.4713237
+ rdsw=107.1278663          prwg=-0.4669177           prwb=0.5
+ wr=1                      wint=0                    lint=7.114942e-9
+ dwg=9.08172e-9            dwb=-1.055419e-8          voff=-0.1022829
+ nfactor=1.5332272         cit=0                     cdsc=2.4e-4
+ cdscd=0                   cdscb=0                   eta0=2.614551e-3
+ etab=-0.0168045           dsub=6.521314e-4          pclm=2.962964
+ pdiblc1=8.221609e-10      pdiblc2=0.0619593         pdiblcb=-1e-3
+ drout=2.184457e-3         pscbe1=1.595578e10        pscbe2=2.659071e-9
+ pvag=7.2529411            delta=0.01                rsh=7.1
+ mobmod=1                  prt=0                     ute=-1.5
+ kt1=-0.11                 kt1l=0                    kt2=0.022
+ ua1=4.31e-9               ub1=-7.61e-18             uc1=-5.6e-11
+ at=3.3e4                  wl=0                      wln=1
+ ww=0                      wwn=1                     wwl=0
+ ll=0                      lln=1                     lw=0
+ lwn=1                     lwl=0                     capmod=2
+ xpart=0.5                 cgdo=3.84e-10             cgso=3.84e-10
+ cgbo=1e-12                cj=1.174253e-3            pb=0.824291
+ mj=0.4102747              cjsw=1.315683e-10         pbsw=0.8945339
+ mjsw=0.1                  cjswg=4.22e-10            pbswg=0.8945339
+ mjswg=0.1                 cf=0                      pvth0=-7.258229e-5
+ prdsw=65.9193707          pk2=2.288865e-3           wketa=0.05
+ lketa=0.0245012           pu0=-1.3182233            pua=-5.72446e-11
+ pub=6.107205e-23          pvsat=-50                 peta0=1e-4
+ pketa=-6.63068e-3
//

parameters  lambda = 0.065u
parameters  vdd_tech=1.2

//multiplication factor for Pmos transistor widths
parameters p_mult=2.0
