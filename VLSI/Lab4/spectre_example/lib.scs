subckt nand2_gen (a b y vddc gndc)
  parameters size=1
    m3 (y a net29 gndc) n_def ws=2*size ls=1
    m4 (net29 b gndc gndc) n_def ws=2*size ls=1
    m2 (y b vddc vddc) p_def ws=1*p_mult*size ls=1
    m1 (y a vddc vddc) p_def ws=1*p_mult*size ls=1
ends nand2_gen

subckt inv_gen (a y vddc gndc)
  parameters size=1
    m2 (y a gndc gndc) n_def ws=1*size ls=1
    m1 (y a vddc vddc) p_def ws=1*p_mult*size  ls=1
ends inv_gen

subckt dut_driver a y vddc gndc
   x1 (a a_2 vddc gndc) inv_gen size=1
   x2 (a_2 y vddc gndc) inv_gen size=2
ends dut_driver

subckt dut_load a y vddc gndc
   x1 (a a_2 vddc gndc) inv_gen size=4
   x2 (a_2 y vddc gndc) inv_gen size=4
ends dut_load
